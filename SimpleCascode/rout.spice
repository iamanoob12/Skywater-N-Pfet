* Test - Telescopic Cascode AC analysis

.param W_n=5 L_n=0.15
.param W_p=5 L_p=0.30
.param scale_n = '2m / 5.561820e-4'
.param scale_p = '2m / 9.045101e-5'

* Include PDK model library
.lib "/usr/local/share/pdk/share/pdk/sky130A/libs.tech/ngspice/sky130.lib.spice" tt

* Power and Bias Sources
Vdd Vdd 0 DC 1.6
Vb1 Vb1 0 DC 0.25
Vb2 Vb2 0 DC -0.15
Vb3 Vb3 0 DC 1.5
Vin Vin 0 DC 1.1 AC 1

* Cascode Transistor Instantiations
Xpfet1 Vdd Vb1 N1 Vdd MY_PFET W_val='W_p' L_val='L_p' m='scale_p'
Xpfet2 N1 Vb2 Vout N1 MY_PFET W_val='W_p' L_val='L_p' m='scale_p'
Xnfet1 Vout Vb3 N2 N2 MY_NFET W_val='W_n' L_val='L_n' m='scale_n'
Xnfet2 N2 Vin 0 0 MY_NFET W_val='W_n' L_val='L_n' m='scale_n'

* Parameterized Subcircuits
.subckt MY_NFET Vd Vg Vs Vb W_val=5 L_val=0.15
   XMN Vd Vg Vs Vb sky130_fd_pr__nfet_01v8 w='W_val' l='L_val' nf=1 ad=1.45 as=1.45 pd=10.58 ps=10.58 nrd=0.058 nrs=0.058 sa=0 sb=0 sd=0 mult=1
.ends MY_NFET

.subckt MY_PFET Vd Vg Vs Vb W_val=5 L_val=0.30
   XMP Vd Vg Vs Vb sky130_fd_pr__pfet_01v8 w='W_val' l='L_val' nf=1 ad=1.45 as=1.45 pd=10.58 ps=10.58 nrd=0.058 nrs=0.058 sa=0 sb=0 sd=0 mult=1
.ends MY_PFET

.control
  save all @m.xpfet1.xmp.msky130_fd_pr__pfet_01v8[gm]  @m.xpfet1.xmp.msky130_fd_pr__pfet_01v8[gds]
  save all @m.xpfet2.xmp.msky130_fd_pr__pfet_01v8[gm]  @m.xpfet2.xmp.msky130_fd_pr__pfet_01v8[gds]
  save all @m.xnfet1.xmn.msky130_fd_pr__nfet_01v8[gm]  @m.xnfet1.xmn.msky130_fd_pr__nfet_01v8[gds]
  save all @m.xnfet2.xmn.msky130_fd_pr__nfet_01v8[gm]  @m.xnfet2.xmn.msky130_fd_pr__nfet_01v8[gds]

  op

  * Small-signal resistances: ro = 1 / gds
  let ro_n1 = 1 / @m.xnfet2.xmn.msky130_fd_pr__nfet_01v8[gds]
  let ro_n2 = 1 / @m.xnfet1.xmn.msky130_fd_pr__nfet_01v8[gds]
  let gm_n2 = @m.xnfet1.xmn.msky130_fd_pr__nfet_01v8[gm]

  let ro_p1 = 1 / @m.xpfet1.xmp.msky130_fd_pr__pfet_01v8[gds]
  let ro_p2 = 1 / @m.xpfet2.xmp.msky130_fd_pr__pfet_01v8[gds]
  let gm_p2 = @m.xpfet2.xmp.msky130_fd_pr__pfet_01v8[gm]

  * NMOS & PMOS branch impedances
  let Rout_n = gm_n2 * ro_n2 * ro_n1 + ro_n1 + ro_n2
  let Rout_p = gm_p2 * ro_p2 * ro_p1 + ro_p1 + ro_p2

  * Total parallel impedance: Rout = Rout_n || Rout_p
  let Rout_total = (Rout_n * Rout_p) / (Rout_n + Rout_p)

  print all
.endc

.end
