* Test - Telescopic Cascode AC analysis

.param W_n=5 L_n=0.15
.param W_p=5 L_p=0.30
.param scale_n = '2m / 5.561820e-4'
.param scale_p = '2m / 9.045101e-5'

* Include PDK model library
.lib "/usr/local/share/pdk/share/pdk/sky130A/libs.tech/ngspice/sky130.lib.spice" tt

* Power and Bias Sources
Vdd Vdd 0 DC 1.6
Vb1 Vb1 0 DC 0.25
Vb2 Vb2 0 DC -0.15
Vb3 Vb3 0 DC 1.5
Vin Vin 0 DC 1.1 AC 1

* Cascode Transistor Instantiations
Xpfet1 Vdd Vb1 N1 Vdd MY_PFET W_val='W_p' L_val='L_p' m='scale_p'
Xpfet2 N1 Vb2 Vout N1 MY_PFET W_val='W_p' L_val='L_p' m='scale_p'
Xnfet1 Vout Vb3 N2 N2 MY_NFET W_val='W_n' L_val='L_n' m='scale_n'
Xnfet2 N2 Vin 0 0 MY_NFET W_val='W_n' L_val='L_n' m='scale_n'

* Parameterized Subcircuits
.subckt MY_NFET Vd Vg Vs Vb W_val=5 L_val=0.15
   XMN Vd Vg Vs Vb sky130_fd_pr__nfet_01v8 w='W_val' l='L_val' nf=1 ad=1.45 as=1.45 pd=10.58 ps=10.58 nrd=0.058 nrs=0.058 sa=0 sb=0 sd=0 mult=1
.ends MY_NFET

.subckt MY_PFET Vd Vg Vs Vb W_val=5 L_val=0.30
   XMP Vd Vg Vs Vb sky130_fd_pr__pfet_01v8 w='W_val' l='L_val' nf=1 ad=1.45 as=1.45 pd=10.58 ps=10.58 nrd=0.058 nrs=0.058 sa=0 sb=0 sd=0 mult=1
.ends MY_PFET

.control
    ac dec 10 1Hz 100GHz
    set units=degrees
    plot db(v(Vout))
    plot ph(v(Vout))
.endc

.end
