*** Current Mirror Circuit ***

.param W_p=5 L_p=0.30
.param W_n=5 L_n=0.15
.param scale_n = '2m / 5.561820e-4'
.param scale_p = '2m / 9.045101e-5'
.lib "/usr/local/share/pdk/share/pdk/sky130A/libs.tech/ngspice/sky130.lib.spice" tt

* Power & Sources
Vdd Vdd 0 DC 0.8
Iref N2 0 DC 2m
Vin Vin 0 DC 1.1

R1 N1 N2 475
* Device Instantiations: Xname Node1 Node2 Node3 Node4 SubcktName Params...
Xpfet1 N1 N2 Vdd Vdd dfpfet W_val='W_p' L_val='L_p' m='scale_p'
Xpfet2 Vout N2 Vdd Vdd dfpfet W_val='W_p' L_val='L_p' m='scale_p'
Xnfet1 Vout Vin 0 0 dfnfet W_val='W_n' L_val='L_n' m='scale_n'

* Parameterized Subcircuits
.subckt dfnfet Vd Vg Vs Vb W_val=5 L_val=0.15
   XMN Vd Vg Vs Vb sky130_fd_pr__nfet_01v8 w='W_val' l='L_val' nf=1 ad=1.45 as=1.45 pd=10.58 ps=10.58 nrd=0.058 nrs=0.058 sa=0 sb=0 sd=0 mult=1
.ends dfnfet

.subckt dfpfet Vd Vg Vs Vb W_val=5 L_val=0.30
   XMP Vd Vg Vs Vb sky130_fd_pr__pfet_01v8 w='W_val' l='L_val' nf=1 ad=1.45 as=1.45 pd=10.58 ps=10.58 nrd=0.058 nrs=0.058 sa=0 sb=0 sd=0 mult=1
.ends dfpfet

.control
  op
  let iout = @m.xpfet2.xmp.msky130_fd_pr__pfet_01v8[id]
  print v(N1) v(Vout) iout
.endc

.end
